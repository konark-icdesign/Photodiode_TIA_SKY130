* first NMOS check - Id vs Vgs
* sky130 1.8V nfet, L kept at 0.5u for now

.lib "$PDK_ROOT/sky130A/libs.tech/ngspice/sky130.lib.spice" tt

VDS d 0 0.9
VGS g 0 0

XM1 d g 0 0 sky130_fd_pr__nfet_01v8 L=0.5u W=10u

.control
set wr_singlescale
set wr_vecnames
dc VGS 0 1.8 0.01
wrdata nmos_idvg.csv v(g) -i(VDS)
quit
.endc

.end
